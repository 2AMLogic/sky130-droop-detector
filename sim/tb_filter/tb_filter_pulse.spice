* tb_filter (part A): design/glitch_filter.spice alone, tt / 27 C, detector supply 3.3 V.
* Stimulus: ideal 0 -> 3.3 V pulses (0.05 ns edges) standing in for comparator
* output pulses; widths are measured at 50 % of the swing. One pulse per width,
* 40 ns apart so the RC node fully recovers between pulses.
* The pulse list and its .meas lines are generated by run.sh.
.lib "__PDK_LIB__" tt
.include "__NETLIST__"
.temp 27
Vdd vdd33 0 3.3
Vin in 0 pwl(__PWL__)
Xdut in vdd33 0 out glitch_filter
Cl out 0 5f

.control
tran 0.02n __TSTOP__
__MEAS__
quit
.endc
.end
