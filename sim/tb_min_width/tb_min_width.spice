* tb_min_width (spec row 7): minimum detected droop width of design/detector_top.spice,
* tt / 27 C, detector supply 3.3 V. Cases are generated by run.sh into the .control block at __CASES__.
* Monitored rail = BEHAVIOURAL ENVELOPE (assumption, spec "Rail model" form 2): a droop from
* 1.8 V to (threshold - 100 mV) with 1 ns linear edges down and back, sized so the width
* at the threshold crossings equals the case width (same arithmetic as
* tb_rail_model_check/gen_envelope.py). Loaded by 1 kohm.
* The live flag must assert: `live` reaches the spec VOH floor (1.44 V) after comparator +
* glitch filter + flag logic; load 100 fF (assumption).
.lib "__PDK_LIB__" tt
.include "__NETLIST__"
.temp 27

Vdd vdd33 0 3.3
Vrail rail 0 1.8
Rrail rail 0 1k
Vs0 s0 0 0
Vs1 s1 0 0
Vclr clr 0 0
Xdut rail s0 s1 clr vdd33 0 live sticky detector_top
Cl live 0 100f

.control
set num_threads=2
__CASES__
quit
.endc
.end
