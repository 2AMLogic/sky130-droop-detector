* tb_iq: quiescent supply current of design/detector_top.spice (spec row 11): each of the
* four select codes ("levels enabled" = the reference, comparator, filter and flag logic
* all biased), monitored rail at nominal 1.8 V, CLR pulsed once at 1-5 us to clear power-up sticky state then low, flag idle. One copy per code,
* each on its own 3.3 V supply source so each current is read separately. Corner,
* temperature and supply are substituted by run.sh. Monitored rail = IDEAL DC SOURCE: a
* quiescent figure, no rail waveform is needed.
.lib "__PDK_LIB__" __PROC__
.include "__NETLIST__"
.temp __TEMP__
.param vsup=__VSUP__
.option method=gear

Vrail rail 0 1.8
Vlo lo 0 0
Vhi hi 0 {vsup}
Vclr clr 0 PWL(0 0 1u 0 1.1u {vsup} 5u {vsup} 5.1u 0)
Vd0 vd0 0 {vsup}
Vd1 vd1 0 {vsup}
Vd2 vd2 0 {vsup}
Vd3 vd3 0 {vsup}
X0 rail lo lo clr vd0 0 l0 st0 detector_top
X1 rail hi lo clr vd1 0 l1 st1 detector_top
X2 rail lo hi clr vd2 0 l2 st2 detector_top
X3 rail hi hi clr vd3 0 l3 st3 detector_top

.control
tran 20n 40u
meas tran iq_l0_ua avg i(Vd0) from=20u to=40u
let a0 = -iq_l0_ua*1e6
echo "RESULT iq_l0_ua = $&a0"
meas tran iq_l1_ua avg i(Vd1) from=20u to=40u
let a1 = -iq_l1_ua*1e6
echo "RESULT iq_l1_ua = $&a1"
meas tran iq_l2_ua avg i(Vd2) from=20u to=40u
let a2 = -iq_l2_ua*1e6
echo "RESULT iq_l2_ua = $&a2"
meas tran iq_l3_ua avg i(Vd3) from=20u to=40u
let a3 = -iq_l3_ua*1e6
echo "RESULT iq_l3_ua = $&a3"
meas tran idle_max_l0 max v(l0) from=20u to=40u
echo "RESULT idle_max_l0 = $&idle_max_l0"
meas tran idle_max_l1 max v(l1) from=20u to=40u
echo "RESULT idle_max_l1 = $&idle_max_l1"
meas tran idle_max_l2 max v(l2) from=20u to=40u
echo "RESULT idle_max_l2 = $&idle_max_l2"
meas tran idle_max_l3 max v(l3) from=20u to=40u
echo "RESULT idle_max_l3 = $&idle_max_l3"
meas tran sticky_max_l0 max v(st0) from=20u to=40u
echo "RESULT sticky_max_l0 = $&sticky_max_l0"
quit
.endc
.end
