* tb_threshold_mc: static trip point of design/detector_top.spice at one select code and
* one detector supply.
* Circuit body for `klt sim` (no .control/.end; klt adds .lib/.temp, the supply alter
* and the DC analysis). The monitored rail Vrail is an IDEAL SOURCE swept slowly
* (static trip point, spec row 5); the rail model is not used because row 5 is a
* static accuracy figure. The trip is the first rising crossing of the detector's
* INTERNAL comparator output `xdut.flag` at half the applied detector supply (__VDD__ / 2,
* a literal klt cannot derive from the supply axis): the same fraction of the comparator
* output swing at every supply, 1.65 V at 3.3 V. The glitch filter and flag logic stay
* connected (they load the node) but `live` / `sticky` are not what is measured.
* Select bits: an asserted bit is driven at the applied detector supply, a deasserted
* bit at ground.
* __NETLIST__, __S0__, __S1__ and __VDD__ are filled in by gen_requests.py.
.include "__NETLIST__"
Vdd vdd33 0 __VDD__
Vrail rail 0 1.9
Vs0 s0 0 __S0__
Vs1 s1 0 __S1__
Vclr clr 0 0
Xdut rail s0 s1 clr vdd33 0 live sticky detector_top
Cl live 0 5f
