* tb_latency (spec row 6): detection latency at 100 mV overdrive of design/detector_top.spice,
* tt / 27 C, detector supply 3.3 V. Cases are generated by run.sh into the .control block at __CASES__.
* Monitored rail = BEHAVIOURAL ENVELOPE (assumption, spec "Rail model" form 2): a source
* falling from the start point to (threshold - 100 mV) with a 1 ns linear edge, held, then
* returning; loaded by 1 kohm as in tb_rail_model_check/gen_envelope.py. An ideal step
* (1 ps edge) is run alongside as the additional case only.
* t = 0 is the instant the stimulus reaches threshold - 100 mV (full overdrive).
* Output flag = `live` (after comparator + glitch filter + flag logic), load 100 fF (assumption).
.lib "__PDK_LIB__" tt
.include "__NETLIST__"
.temp 27

Vdd vdd33 0 3.3
Vrail rail 0 1.8
Rrail rail 0 1k
Vs0 s0 0 0
Vs1 s1 0 0
Vclr clr 0 0
Xdut rail s0 s1 clr vdd33 0 live sticky detector_top
Cl live 0 100f

.control
set num_threads=2
__CASES__
quit
.endc
.end
