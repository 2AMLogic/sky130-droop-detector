* tb_supply_headroom (spec row 2): does design/detector_top.spice still decide correctly with
* the monitored rail collapsing while the 3.3 V detector supply is at its minimum (2.97 V)
* and while that supply itself sags with the event? tt / 27 C. Cases are generated by run.sh
* into the .control block at __CASES__.
* Monitored rail = BEHAVIOURAL ENVELOPE (assumption, spec "Rail model" form 2), 1 ns linear
* edges, loaded by 1 kohm. The supply sag is an ASSUMED stimulus (the spec fixes no sag depth
* or timing): a trapezoid from the supply value down by the case depth, 10 ns edges, starting
* 10 ns before the rail edge and recovering after it. Output flag = `live`, load 100 fF.
.lib "__PDK_LIB__" tt
.include "__NETLIST__"
.temp 27

Vdd vdd33 0 3.3
Vrail rail 0 1.8
Rrail rail 0 1k
Vs0 s0 0 0
Vs1 s1 0 0
Vclr clr 0 0
Xdut rail s0 s1 clr vdd33 0 live sticky detector_top
Cl live 0 100f

.control
set num_threads=2
__CASES__
quit
.endc
.end
